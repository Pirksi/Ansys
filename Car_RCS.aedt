# Ansys Electronics Desktop project, version 2024.2
materials:
  vacuum: permittivity=1

design Theta (HFSS, HFSS Modal Network, model units mm)
geometry:
  wheels, wheels_1, wheels_2, wheels_3 [non-model] = imported_body(D:\_HFSS student\2nd-vdeo-Car\car_model.step)
  body = imported_body(D:\_HFSS student\2nd-vdeo-Car\car_model.step)
  RadiatingSurface [vacuum] = region(absolute_offset=88.183422mm on all sides)
  group car_model = wheels, wheels_1, wheels_2, wheels_3, body
boundaries and excitations:
  PerfE1: Perfect E Objects=body
  Open1: Radiation Objects=RadiatingSurface
  IncPWave1: Plane Incident Wave PhiStart=180deg PhiStop=180deg PhiPoints=1 ThetaStart=-90deg ThetaStop=90deg ThetaPoints=91 EoPhi=1 EoTheta=0 OriginX=0mm OriginY=0mm OriginZ=0mm IsPropagating
setups:
  Setup1: HfssDriven Frequency=1134MHz MaxDeltaE=0.1 MaximumPasses=6 MinimumPasses=1 MinimumConvergedPasses=1 PercentRefinement=30 BasisOrder=1 DrivenSolverType="Direct Solver"
source amplitudes:
  IncPWave1:1: 1 0deg
radiation setups:
  3D: Infinite Sphere Theta=0deg..180deg step 2deg Phi=-180deg..180deg step 2deg
  Elevation: Infinite Sphere Theta=-180deg..180deg step 1deg Phi=0deg..90deg step 90deg
  Azimuth: Infinite Sphere Theta=90deg..90deg step 0deg Phi=-180deg..180deg step 1deg
